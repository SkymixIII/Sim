* A9_defauts
.include ../models/composants.lib

.include /home/claude/sim/projets/timecode-ltc/sim/gen/bnc.inc
.include /home/claude/sim/projets/timecode-ltc/sim/gen/entree.inc
Va v3v3a 0 3.3
Vmtx mode_tx 0 1
Vmrx mode_rx 0 0
Rout_idle ltc_out_bnc 0 100k
Vf1 f1 0 pwl(0 0 1m 0 1.001m 12 30m 12 30.001m 0)
Vf2 f2 0 sin(0 15 2k 40m)
Vf3 f3 0 pwl(0 0 70m 0 70.01m 24 71m 24 71.01m 0)
Bsum fsum 0 V = V(f1) + V(f2)*(time > 40m && time < 60m ? 1 : 0) + V(f3)
Rsrc fsum bnc_c 50

.control
set wr_singlescale
set wr_vecnames
option numdgt=7
tran 2u 80m 0 2u
wrdata A9_defauts.dat v(bnc_c) v(in_a) v(cmp_inn) v(cmp_out) i(va) v(in_ac) v(ltc_in_raw)
quit
.endc
.end
