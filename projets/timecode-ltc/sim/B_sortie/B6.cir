* B6
.include ../models/composants.lib

.include /home/claude/sim/projets/timecode-ltc/sim/gen/bnc.inc
.include /home/claude/sim/projets/timecode-ltc/sim/gen/sortie.inc
Va v3v3a 0 3.3
Vd v3v3 0 3.3
Vmtx mode_tx 0 0
Vmrx mode_rx 0 1
Actl %vd([ctl 0]) ctlmod
.model ctlmod filesource (file="b6_gpio.pwl" amploffset=[0] amplscale=[1] timeoffset=0 timescale=1 timerelative=false amplstep=false)
* GPIO5 en entrée (haute impédance) tant que le LTC n'est pas généré : la
* liaison C7//C8 est alors pré-chargée à VCC/2 par R11/R12 (voir rapport)
Voe oe 0 pwl(0 0 0.0018 0 0.0018009999999999999 1)
XG ltc_tx_gpio v3v3 0 ctl oe ESP_GPIO_OUT
* Chemin d'entrée, isolé en RX : R1 seule reste sur son contact
Rin_idle ltc_in_raw 0 1Meg
* Câble (capacité répartie ramenée en deux moitiés autour de 0,1 ohm/m)
Cc1 bnc_c 0 3.35e-09
Rcab bnc_c far 10.0
Cc2 far 0 3.35e-09
Rload far 0 10000.0

.control
set wr_singlescale
set wr_vecnames
option numdgt=7
tran 0.5u 0.20400000000000001 0 0.5u
wrdata B6.dat v(bnc_c) v(far) v(out_sh) v(opa_out) v(ltc_tx_gpio) i(va) v(out_p)
quit
.endc
.end
