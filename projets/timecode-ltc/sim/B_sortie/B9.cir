* B9
.include ../models/composants.lib

.include /home/claude/sim/projets/timecode-ltc/sim/gen/bnc.inc
.include /home/claude/sim/projets/timecode-ltc/sim/gen/sortie.inc
.include boitier2_tx.inc
Va v3v3a 0 3.3
Vd v3v3 0 3.3
Vmtx mode_tx 0 0
Vmrx mode_rx 0 1
Actl %vd([ctl 0]) ctlmod
.model ctlmod filesource (file="b9_gpio.pwl" amploffset=[0] amplscale=[1] timeoffset=0 timescale=1 timerelative=false amplstep=false)
* GPIO5 en entrée (haute impédance) tant que le LTC n'est pas généré : la
* liaison C7//C8 est alors pré-chargée à VCC/2 par R11/R12 (voir rapport)
Voe oe 0 pwl(0 0 0.0018 0 0.0018009999999999999 1)
XG ltc_tx_gpio v3v3 0 ctl oe ESP_GPIO_OUT
Rin_idle ltc_in_raw 0 1Meg
Cc1 bnc_c 0 335p
Rcab bnc_c b2_bnc_c 1
Cc2 b2_bnc_c 0 335p
Rb2_idle b2_ltc_out_bnc 0 100k
XESP2 b2_ltc_rx_gpio v3v3 0 ESP_GPIO_IN

.control
set wr_singlescale
set wr_vecnames
option numdgt=7
tran 0.5u 0.244 0 0.5u
wrdata B9.dat v(bnc_c) v(b2_bnc_c) v(out_sh) v(opa_out) v(ltc_tx_gpio) i(va) v(out_p) v(b2_ltc_rx_gpio) v(b2_cmp_inn) v(b2_cmp_inp)
quit
.endc
.end
